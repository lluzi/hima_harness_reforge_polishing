// Kuijk bandgap bench: synth180 corner tt, vdd 3.3 V, copy 6 (en1us)
simulator lang=spectre
global 0
simulator lang=spice
.include "<pdkRoot>/synth180/design.inc"
.lib "<pdkRoot>/synth180/bandgap.lib" mos_tt
.lib "<pdkRoot>/synth180/bandgap.lib" bjt_tt
.lib "<pdkRoot>/synth180/bandgap.lib" res_tt
.include "./cell.spice"
simulator lang=spectre
opts options temp=27 tnom=27 rawfmt=psfascii save=selected cmin=1e-14
VDD6 (vdd6 0) vsource dc=3.3
VEN6 (en6 0) vsource type=pwl wave=[0 0 10u 0 11u 3.3]
GIB6 (ib6 0 en6 0) vccs gm=1.51515e-07
X6 (vdd6 0 en6 ib6 vbg6 g6 g6) bandgap_lb
save vbg6
al_p27 alter param=temp value=27
tr_p27 tran stop=300u maxstep=1u errpreset=moderate
